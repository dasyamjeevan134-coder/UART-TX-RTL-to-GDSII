* NGSPICE file created from uart_tx.ext - technology: sky130A

* Black-box entry subcircuit for sky130_fd_sc_hd__inv_2 abstract view
.subckt sky130_fd_sc_hd__inv_2 A VGND VNB VPB VPWR Y
.ends

* Black-box entry subcircuit for sky130_fd_sc_hd__fill_1 abstract view
.subckt sky130_fd_sc_hd__fill_1 VGND VNB VPB VPWR
.ends

* Black-box entry subcircuit for sky130_ef_sc_hd__decap_12 abstract view
.subckt sky130_ef_sc_hd__decap_12 VPWR VGND VPB VNB
.ends

* Black-box entry subcircuit for sky130_fd_sc_hd__nand3_1 abstract view
.subckt sky130_fd_sc_hd__nand3_1 A B C VGND VNB VPB VPWR Y
.ends

* Black-box entry subcircuit for sky130_fd_sc_hd__dfrtp_1 abstract view
.subckt sky130_fd_sc_hd__dfrtp_1 CLK D RESET_B VGND VNB VPB VPWR Q
.ends

* Black-box entry subcircuit for sky130_fd_sc_hd__decap_4 abstract view
.subckt sky130_fd_sc_hd__decap_4 VGND VNB VPB VPWR
.ends

* Black-box entry subcircuit for sky130_fd_sc_hd__tapvpwrvgnd_1 abstract view
.subckt sky130_fd_sc_hd__tapvpwrvgnd_1 VGND VPWR
.ends

* Black-box entry subcircuit for sky130_fd_sc_hd__decap_8 abstract view
.subckt sky130_fd_sc_hd__decap_8 VGND VNB VPB VPWR
.ends

* Black-box entry subcircuit for sky130_fd_sc_hd__buf_4 abstract view
.subckt sky130_fd_sc_hd__buf_4 A VGND VNB VPB VPWR X
.ends

* Black-box entry subcircuit for sky130_fd_sc_hd__decap_6 abstract view
.subckt sky130_fd_sc_hd__decap_6 VGND VNB VPB VPWR
.ends

* Black-box entry subcircuit for sky130_fd_sc_hd__dlygate4sd3_1 abstract view
.subckt sky130_fd_sc_hd__dlygate4sd3_1 A VGND VNB VPB VPWR X
.ends

* Black-box entry subcircuit for sky130_fd_sc_hd__a22o_1 abstract view
.subckt sky130_fd_sc_hd__a22o_1 A1 A2 B1 B2 VGND VNB VPB VPWR X
.ends

* Black-box entry subcircuit for sky130_fd_sc_hd__a311o_1 abstract view
.subckt sky130_fd_sc_hd__a311o_1 A1 A2 A3 B1 C1 VGND VNB VPB VPWR X
.ends

* Black-box entry subcircuit for sky130_fd_sc_hd__fill_2 abstract view
.subckt sky130_fd_sc_hd__fill_2 VGND VNB VPB VPWR
.ends

* Black-box entry subcircuit for sky130_fd_sc_hd__decap_3 abstract view
.subckt sky130_fd_sc_hd__decap_3 VGND VNB VPB VPWR
.ends

* Black-box entry subcircuit for sky130_fd_sc_hd__clkbuf_4 abstract view
.subckt sky130_fd_sc_hd__clkbuf_4 A VGND VNB VPB VPWR X
.ends

* Black-box entry subcircuit for sky130_fd_sc_hd__or2b_1 abstract view
.subckt sky130_fd_sc_hd__or2b_1 A B_N VGND VNB VPB VPWR X
.ends

* Black-box entry subcircuit for sky130_fd_sc_hd__or3_1 abstract view
.subckt sky130_fd_sc_hd__or3_1 A B C VGND VNB VPB VPWR X
.ends

* Black-box entry subcircuit for sky130_fd_sc_hd__mux4_1 abstract view
.subckt sky130_fd_sc_hd__mux4_1 A0 A1 A2 A3 S0 S1 VGND VNB VPB VPWR X
.ends

* Black-box entry subcircuit for sky130_fd_sc_hd__a21bo_1 abstract view
.subckt sky130_fd_sc_hd__a21bo_1 A1 A2 B1_N VGND VNB VPB VPWR X
.ends

* Black-box entry subcircuit for sky130_fd_sc_hd__a21boi_1 abstract view
.subckt sky130_fd_sc_hd__a21boi_1 A1 A2 B1_N VGND VNB VPB VPWR Y
.ends

* Black-box entry subcircuit for sky130_fd_sc_hd__or2_1 abstract view
.subckt sky130_fd_sc_hd__or2_1 A B VGND VNB VPB VPWR X
.ends

* Black-box entry subcircuit for sky130_fd_sc_hd__or4_1 abstract view
.subckt sky130_fd_sc_hd__or4_1 A B C D VGND VNB VPB VPWR X
.ends

* Black-box entry subcircuit for sky130_fd_sc_hd__o211a_1 abstract view
.subckt sky130_fd_sc_hd__o211a_1 A1 A2 B1 C1 VGND VNB VPB VPWR X
.ends

* Black-box entry subcircuit for sky130_fd_sc_hd__dfrtp_2 abstract view
.subckt sky130_fd_sc_hd__dfrtp_2 CLK D RESET_B VGND VNB VPB VPWR Q
.ends

* Black-box entry subcircuit for sky130_fd_sc_hd__clkbuf_1 abstract view
.subckt sky130_fd_sc_hd__clkbuf_1 A VGND VNB VPB VPWR X
.ends

* Black-box entry subcircuit for sky130_fd_sc_hd__or4_2 abstract view
.subckt sky130_fd_sc_hd__or4_2 A B C D VGND VNB VPB VPWR X
.ends

* Black-box entry subcircuit for sky130_fd_sc_hd__and4_2 abstract view
.subckt sky130_fd_sc_hd__and4_2 A B C D VGND VNB VPB VPWR X
.ends

* Black-box entry subcircuit for sky130_fd_sc_hd__and2_1 abstract view
.subckt sky130_fd_sc_hd__and2_1 A B VGND VNB VPB VPWR X
.ends

* Black-box entry subcircuit for sky130_fd_sc_hd__clkbuf_16 abstract view
.subckt sky130_fd_sc_hd__clkbuf_16 A VGND VNB VPB VPWR X
.ends

* Black-box entry subcircuit for sky130_fd_sc_hd__a21oi_1 abstract view
.subckt sky130_fd_sc_hd__a21oi_1 A1 A2 B1 VGND VNB VPB VPWR Y
.ends

* Black-box entry subcircuit for sky130_fd_sc_hd__dfstp_1 abstract view
.subckt sky130_fd_sc_hd__dfstp_1 CLK D SET_B VGND VNB VPB VPWR Q
.ends

* Black-box entry subcircuit for sky130_fd_sc_hd__and4_1 abstract view
.subckt sky130_fd_sc_hd__and4_1 A B C D VGND VNB VPB VPWR X
.ends

* Black-box entry subcircuit for sky130_fd_sc_hd__nand4_1 abstract view
.subckt sky130_fd_sc_hd__nand4_1 A B C D VGND VNB VPB VPWR Y
.ends

* Black-box entry subcircuit for sky130_fd_sc_hd__mux2_1 abstract view
.subckt sky130_fd_sc_hd__mux2_1 A0 A1 S VGND VNB VPB VPWR X
.ends

* Black-box entry subcircuit for sky130_fd_sc_hd__a31o_1 abstract view
.subckt sky130_fd_sc_hd__a31o_1 A1 A2 A3 B1 VGND VNB VPB VPWR X
.ends

* Black-box entry subcircuit for sky130_fd_sc_hd__nor2_1 abstract view
.subckt sky130_fd_sc_hd__nor2_1 A B VGND VNB VPB VPWR Y
.ends

* Black-box entry subcircuit for sky130_fd_sc_hd__o21a_1 abstract view
.subckt sky130_fd_sc_hd__o21a_1 A1 A2 B1 VGND VNB VPB VPWR X
.ends

* Black-box entry subcircuit for sky130_fd_sc_hd__nand2_4 abstract view
.subckt sky130_fd_sc_hd__nand2_4 A B VGND VNB VPB VPWR Y
.ends

* Black-box entry subcircuit for sky130_fd_sc_hd__and3_1 abstract view
.subckt sky130_fd_sc_hd__and3_1 A B C VGND VNB VPB VPWR X
.ends

* Black-box entry subcircuit for sky130_fd_sc_hd__dfrtp_4 abstract view
.subckt sky130_fd_sc_hd__dfrtp_4 CLK D RESET_B VGND VNB VPB VPWR Q
.ends

* Black-box entry subcircuit for sky130_fd_sc_hd__nand2_1 abstract view
.subckt sky130_fd_sc_hd__nand2_1 A B VGND VNB VPB VPWR Y
.ends

* Black-box entry subcircuit for sky130_fd_sc_hd__a21o_1 abstract view
.subckt sky130_fd_sc_hd__a21o_1 A1 A2 B1 VGND VNB VPB VPWR X
.ends

* Black-box entry subcircuit for sky130_fd_sc_hd__buf_1 abstract view
.subckt sky130_fd_sc_hd__buf_1 A VGND VNB VPB VPWR X
.ends

* Black-box entry subcircuit for sky130_fd_sc_hd__clkbuf_2 abstract view
.subckt sky130_fd_sc_hd__clkbuf_2 A VGND VNB VPB VPWR X
.ends

* Black-box entry subcircuit for sky130_fd_sc_hd__buf_2 abstract view
.subckt sky130_fd_sc_hd__buf_2 A VGND VNB VPB VPWR X
.ends

* Black-box entry subcircuit for sky130_fd_sc_hd__o21ai_1 abstract view
.subckt sky130_fd_sc_hd__o21ai_1 A1 A2 B1 VGND VNB VPB VPWR Y
.ends

* Black-box entry subcircuit for sky130_fd_sc_hd__and2b_1 abstract view
.subckt sky130_fd_sc_hd__and2b_1 A_N B VGND VNB VPB VPWR X
.ends

* Black-box entry subcircuit for sky130_fd_sc_hd__or3_4 abstract view
.subckt sky130_fd_sc_hd__or3_4 A B C VGND VNB VPB VPWR X
.ends

* Black-box entry subcircuit for sky130_fd_sc_hd__nand3_2 abstract view
.subckt sky130_fd_sc_hd__nand3_2 A B C VGND VNB VPB VPWR Y
.ends

* Black-box entry subcircuit for sky130_fd_sc_hd__mux2_2 abstract view
.subckt sky130_fd_sc_hd__mux2_2 A0 A1 S VGND VNB VPB VPWR X
.ends

* Black-box entry subcircuit for sky130_fd_sc_hd__nor4_1 abstract view
.subckt sky130_fd_sc_hd__nor4_1 A B C D VGND VNB VPB VPWR Y
.ends

* Black-box entry subcircuit for sky130_fd_sc_hd__and3_2 abstract view
.subckt sky130_fd_sc_hd__and3_2 A B C VGND VNB VPB VPWR X
.ends

.subckt uart_tx VGND VPWR busy clk data[0] data[1] data[2] data[3] data[4] data[5]
+ data[6] data[7] reset start tx
X_294_ net9 VGND VGND VPWR VPWR _035_ sky130_fd_sc_hd__inv_2
XFILLER_0_13_84 VGND VGND VPWR VPWR sky130_fd_sc_hd__fill_1
XFILLER_0_24_94 VPWR VGND VPWR VGND sky130_ef_sc_hd__decap_12
XFILLER_0_24_83 VGND VGND VPWR VPWR sky130_fd_sc_hd__fill_1
X_277_ _144_ VGND VGND VPWR VPWR _053_ sky130_fd_sc_hd__inv_2
X_200_ baud_count\[1\] baud_count\[0\] baud_count\[2\] VGND VGND VPWR VPWR _100_ sky130_fd_sc_hd__nand3_1
X_329_ clknet_2_1__leaf_clk _006_ _036_ VGND VGND VPWR VPWR baud_count\[15\] sky130_fd_sc_hd__dfrtp_1
XFILLER_0_0_29 VGND VGND VPWR VPWR sky130_fd_sc_hd__fill_1
XFILLER_0_19_94 VPWR VGND VPWR VGND sky130_ef_sc_hd__decap_12
XFILLER_0_16_139 VGND VGND VPWR VPWR sky130_fd_sc_hd__fill_1
XFILLER_0_16_40 VGND VGND VPWR VPWR sky130_fd_sc_hd__decap_4
XTAP_112 VGND VPWR sky130_fd_sc_hd__tapvpwrvgnd_1
XTAP_101 VGND VPWR sky130_fd_sc_hd__tapvpwrvgnd_1
X_293_ net9 VGND VGND VPWR VPWR _034_ sky130_fd_sc_hd__inv_2
XFILLER_0_2_109 VPWR VGND VPWR VGND sky130_ef_sc_hd__decap_12
XFILLER_0_13_96 VGND VGND VPWR VPWR sky130_fd_sc_hd__decap_8
X_276_ _144_ VGND VGND VPWR VPWR _052_ sky130_fd_sc_hd__inv_2
XFILLER_0_4_94 VPWR VGND VPWR VGND sky130_ef_sc_hd__decap_12
X_328_ clknet_2_1__leaf_clk _005_ _035_ VGND VGND VPWR VPWR baud_count\[14\] sky130_fd_sc_hd__dfrtp_1
X_259_ net9 VGND VGND VPWR VPWR _143_ sky130_fd_sc_hd__buf_4
XFILLER_0_9_28 VGND VGND VPWR VPWR sky130_fd_sc_hd__fill_1
XFILLER_0_9_39 VGND VGND VPWR VPWR sky130_fd_sc_hd__fill_1
XFILLER_0_10_42 VGND VGND VPWR VPWR sky130_fd_sc_hd__decap_8
XFILLER_0_10_64 VGND VGND VPWR VPWR sky130_fd_sc_hd__decap_6
XFILLER_0_21_41 VPWR VGND VPWR VGND sky130_ef_sc_hd__decap_12
Xhold20 baud_count\[12\] VGND VGND VPWR VPWR net33 sky130_fd_sc_hd__dlygate4sd3_1
XFILLER_0_15_140 VGND VGND VPWR VPWR sky130_fd_sc_hd__decap_6
XFILLER_0_1_51 VGND VGND VPWR VPWR sky130_fd_sc_hd__fill_1
XFILLER_0_16_85 VGND VGND VPWR VPWR sky130_fd_sc_hd__decap_8
XFILLER_0_12_110 VPWR VGND VPWR VGND sky130_ef_sc_hd__decap_12
XTAP_113 VGND VPWR sky130_fd_sc_hd__tapvpwrvgnd_1
XTAP_102 VGND VPWR sky130_fd_sc_hd__tapvpwrvgnd_1
X_292_ net9 VGND VGND VPWR VPWR _033_ sky130_fd_sc_hd__inv_2
X_275_ _144_ VGND VGND VPWR VPWR _051_ sky130_fd_sc_hd__inv_2
XFILLER_0_24_85 VGND VGND VPWR VPWR sky130_fd_sc_hd__decap_6
X_327_ clknet_2_1__leaf_clk _004_ _034_ VGND VGND VPWR VPWR baud_count\[13\] sky130_fd_sc_hd__dfrtp_1
X_189_ net15 _080_ _092_ state\[1\] VGND VGND VPWR VPWR _017_ sky130_fd_sc_hd__a22o_1
X_258_ state\[1\] _140_ _142_ net19 state\[0\] VGND VGND VPWR VPWR _147_ sky130_fd_sc_hd__a311o_1
XFILLER_0_21_86 VGND VGND VPWR VPWR sky130_fd_sc_hd__fill_2
XFILLER_0_21_53 VGND VGND VPWR VPWR sky130_fd_sc_hd__decap_3
XFILLER_0_21_31 VGND VGND VPWR VPWR sky130_fd_sc_hd__decap_6
XFILLER_0_21_111 VGND VGND VPWR VPWR sky130_fd_sc_hd__fill_1
Xhold10 _012_ VGND VGND VPWR VPWR net23 sky130_fd_sc_hd__dlygate4sd3_1
XFILLER_0_6_19 VGND VGND VPWR VPWR sky130_fd_sc_hd__fill_1
Xhold21 baud_count\[4\] VGND VGND VPWR VPWR net34 sky130_fd_sc_hd__dlygate4sd3_1
XFILLER_0_12_100 VGND VGND VPWR VPWR sky130_fd_sc_hd__fill_1
XFILLER_0_12_122 VPWR VGND VPWR VGND sky130_ef_sc_hd__decap_12
Xoutput11 net11 VGND VGND VPWR VPWR busy sky130_fd_sc_hd__clkbuf_4
XFILLER_0_9_3 VPWR VGND VPWR VGND sky130_ef_sc_hd__decap_12
XTAP_114 VGND VPWR sky130_fd_sc_hd__tapvpwrvgnd_1
XTAP_103 VGND VPWR sky130_fd_sc_hd__tapvpwrvgnd_1
X_291_ _145_ VGND VGND VPWR VPWR _032_ sky130_fd_sc_hd__inv_2
XFILLER_0_4_130 VGND VGND VPWR VPWR sky130_fd_sc_hd__decap_8
XFILLER_0_4_141 VGND VGND VPWR VPWR sky130_fd_sc_hd__decap_6
XFILLER_0_7_62 VPWR VGND VPWR VGND sky130_ef_sc_hd__decap_12
XFILLER_0_13_76 VGND VGND VPWR VPWR sky130_fd_sc_hd__fill_1
XFILLER_0_1_111 VGND VGND VPWR VPWR sky130_fd_sc_hd__fill_1
X_274_ _144_ VGND VGND VPWR VPWR _050_ sky130_fd_sc_hd__inv_2
XFILLER_0_24_64 VPWR VGND VPWR VGND sky130_ef_sc_hd__decap_12
XFILLER_0_24_20 VGND VGND VPWR VPWR sky130_fd_sc_hd__decap_8
XFILLER_0_4_85 VGND VGND VPWR VPWR sky130_fd_sc_hd__fill_1
X_326_ clknet_2_1__leaf_clk _003_ _033_ VGND VGND VPWR VPWR baud_count\[12\] sky130_fd_sc_hd__dfrtp_1
X_257_ _141_ bit_index\[2\] VGND VGND VPWR VPWR _142_ sky130_fd_sc_hd__or2b_1
XFILLER_0_10_11 VGND VGND VPWR VPWR sky130_fd_sc_hd__decap_3
XFILLER_0_10_33 VGND VGND VPWR VPWR sky130_fd_sc_hd__fill_1
X_188_ net17 _090_ _075_ VGND VGND VPWR VPWR _092_ sky130_fd_sc_hd__or3_1
XFILLER_0_19_106 VGND VGND VPWR VPWR sky130_fd_sc_hd__decap_6
X_309_ clknet_2_3__leaf_clk _061_ _050_ VGND VGND VPWR VPWR data_reg\[3\] sky130_fd_sc_hd__dfrtp_1
XFILLER_0_24_131 VGND VGND VPWR VPWR sky130_fd_sc_hd__fill_1
Xhold22 data_reg\[0\] VGND VGND VPWR VPWR net35 sky130_fd_sc_hd__dlygate4sd3_1
Xhold11 bit_index\[0\] VGND VGND VPWR VPWR net24 sky130_fd_sc_hd__dlygate4sd3_1
XFILLER_0_12_134 VGND VGND VPWR VPWR sky130_fd_sc_hd__decap_6
Xoutput12 net12 VGND VGND VPWR VPWR tx sky130_fd_sc_hd__clkbuf_4
XTAP_115 VGND VPWR sky130_fd_sc_hd__tapvpwrvgnd_1
XTAP_104 VGND VPWR sky130_fd_sc_hd__tapvpwrvgnd_1
XFILLER_0_7_74 VGND VGND VPWR VPWR sky130_fd_sc_hd__decap_3
X_290_ _145_ VGND VGND VPWR VPWR _031_ sky130_fd_sc_hd__inv_2
XFILLER_0_13_11 VGND VGND VPWR VPWR sky130_fd_sc_hd__decap_3
XFILLER_0_13_55 VGND VGND VPWR VPWR sky130_fd_sc_hd__fill_1
XFILLER_0_1_145 VGND VGND VPWR VPWR sky130_fd_sc_hd__fill_2
X_273_ _144_ VGND VGND VPWR VPWR _049_ sky130_fd_sc_hd__inv_2
XFILLER_0_24_43 VGND VGND VPWR VPWR sky130_fd_sc_hd__decap_3
X_256_ data_reg\[4\] data_reg\[5\] data_reg\[6\] data_reg\[7\] bit_index\[0\] bit_index\[1\]
+ VGND VGND VPWR VPWR _141_ sky130_fd_sc_hd__mux4_1
XFILLER_0_19_65 VGND VGND VPWR VPWR sky130_fd_sc_hd__fill_1
XFILLER_0_19_54 VGND VGND VPWR VPWR sky130_fd_sc_hd__fill_2
X_325_ clknet_2_1__leaf_clk _002_ _032_ VGND VGND VPWR VPWR baud_count\[11\] sky130_fd_sc_hd__dfrtp_1
XFILLER_0_10_23 VGND VGND VPWR VPWR sky130_fd_sc_hd__decap_4
X_187_ net19 _090_ _091_ VGND VGND VPWR VPWR _019_ sky130_fd_sc_hd__a21bo_1
X_308_ clknet_2_1__leaf_clk _060_ _049_ VGND VGND VPWR VPWR data_reg\[2\] sky130_fd_sc_hd__dfrtp_1
X_239_ baud_count\[12\] _127_ _095_ VGND VGND VPWR VPWR _129_ sky130_fd_sc_hd__a21boi_1
Xhold12 data_reg\[5\] VGND VGND VPWR VPWR net25 sky130_fd_sc_hd__dlygate4sd3_1
Xhold23 state\[2\] VGND VGND VPWR VPWR net36 sky130_fd_sc_hd__dlygate4sd3_1
XFILLER_0_21_146 VGND VGND VPWR VPWR sky130_fd_sc_hd__fill_1
XFILLER_0_21_113 VGND VGND VPWR VPWR sky130_fd_sc_hd__fill_1
XFILLER_0_7_140 VGND VGND VPWR VPWR sky130_fd_sc_hd__decap_6
XTAP_116 VGND VPWR sky130_fd_sc_hd__tapvpwrvgnd_1
XTAP_105 VGND VPWR sky130_fd_sc_hd__tapvpwrvgnd_1
XFILLER_0_7_31 VGND VGND VPWR VPWR sky130_fd_sc_hd__fill_1
XFILLER_0_1_113 VPWR VGND VPWR VGND sky130_ef_sc_hd__decap_12
X_272_ _144_ VGND VGND VPWR VPWR _048_ sky130_fd_sc_hd__inv_2
XFILLER_0_24_55 VGND VGND VPWR VPWR sky130_fd_sc_hd__fill_1
XFILLER_0_4_76 VGND VGND VPWR VPWR sky130_fd_sc_hd__decap_8
X_255_ bit_index\[2\] _139_ VGND VGND VPWR VPWR _140_ sky130_fd_sc_hd__or2_1
X_186_ bit_index\[3\] _086_ _090_ _075_ VGND VGND VPWR VPWR _091_ sky130_fd_sc_hd__or4_1
X_324_ clknet_2_1__leaf_clk _001_ _031_ VGND VGND VPWR VPWR baud_count\[10\] sky130_fd_sc_hd__dfrtp_1
XFILLER_0_18_141 VGND VGND VPWR VPWR sky130_fd_sc_hd__decap_6
X_307_ clknet_2_1__leaf_clk _059_ _048_ VGND VGND VPWR VPWR data_reg\[1\] sky130_fd_sc_hd__dfrtp_1
XFILLER_0_21_23 VGND VGND VPWR VPWR sky130_fd_sc_hd__decap_3
XFILLER_0_1_55 VGND VGND VPWR VPWR sky130_fd_sc_hd__fill_1
X_169_ baud_count\[5\] baud_count\[4\] baud_count\[7\] baud_count\[6\] VGND VGND VPWR
+ VPWR _079_ sky130_fd_sc_hd__or4_1
X_238_ net18 _125_ _128_ _095_ VGND VGND VPWR VPWR _002_ sky130_fd_sc_hd__o211a_1
Xhold13 data_reg\[7\] VGND VGND VPWR VPWR net26 sky130_fd_sc_hd__dlygate4sd3_1
XFILLER_0_16_67 VGND VGND VPWR VPWR sky130_fd_sc_hd__fill_1
XFILLER_0_18_3 VGND VGND VPWR VPWR sky130_fd_sc_hd__decap_4
XTAP_106 VGND VPWR sky130_fd_sc_hd__tapvpwrvgnd_1
XPHY_0 VGND VGND VPWR VPWR sky130_fd_sc_hd__decap_3
XFILLER_0_7_43 VPWR VGND VPWR VGND sky130_ef_sc_hd__decap_12
XFILLER_0_7_98 VPWR VGND VPWR VGND sky130_ef_sc_hd__decap_12
XFILLER_0_7_3 VGND VGND VPWR VPWR sky130_fd_sc_hd__decap_8
XFILLER_0_1_125 VPWR VGND VPWR VGND sky130_ef_sc_hd__decap_12
XFILLER_0_1_103 VGND VGND VPWR VPWR sky130_fd_sc_hd__decap_8
XFILLER_0_13_35 VGND VGND VPWR VPWR sky130_fd_sc_hd__fill_1
X_271_ _144_ VGND VGND VPWR VPWR _047_ sky130_fd_sc_hd__inv_2
X_254_ data_reg\[0\] data_reg\[1\] data_reg\[2\] data_reg\[3\] bit_index\[0\] bit_index\[1\]
+ VGND VGND VPWR VPWR _139_ sky130_fd_sc_hd__mux4_1
X_185_ net15 _090_ _066_ VGND VGND VPWR VPWR _018_ sky130_fd_sc_hd__a21bo_1
X_323_ clknet_2_1__leaf_clk _015_ _030_ VGND VGND VPWR VPWR baud_count\[9\] sky130_fd_sc_hd__dfrtp_1
X_306_ clknet_2_1__leaf_clk _058_ _047_ VGND VGND VPWR VPWR data_reg\[0\] sky130_fd_sc_hd__dfrtp_1
X_168_ baud_count\[9\] baud_count\[8\] baud_count\[11\] baud_count\[10\] VGND VGND
+ VPWR VPWR _078_ sky130_fd_sc_hd__or4_1
X_237_ _127_ VGND VGND VPWR VPWR _128_ sky130_fd_sc_hd__inv_2
Xhold14 data_reg\[6\] VGND VGND VPWR VPWR net27 sky130_fd_sc_hd__dlygate4sd3_1
XFILLER_0_1_67 VPWR VGND VPWR VGND sky130_ef_sc_hd__decap_12
XTAP_107 VGND VPWR sky130_fd_sc_hd__tapvpwrvgnd_1
XPHY_1 VGND VGND VPWR VPWR sky130_fd_sc_hd__decap_3
XFILLER_0_7_11 VGND VGND VPWR VPWR sky130_fd_sc_hd__fill_2
XFILLER_0_7_55 VGND VGND VPWR VPWR sky130_fd_sc_hd__fill_1
XFILLER_0_1_137 VGND VGND VPWR VPWR sky130_fd_sc_hd__decap_8
X_270_ net9 VGND VGND VPWR VPWR _144_ sky130_fd_sc_hd__buf_4
XFILLER_0_24_79 VGND VGND VPWR VPWR sky130_fd_sc_hd__decap_4
XFILLER_0_24_57 VGND VGND VPWR VPWR sky130_fd_sc_hd__decap_4
XFILLER_0_24_35 VGND VGND VPWR VPWR sky130_fd_sc_hd__decap_8
X_322_ clknet_2_0__leaf_clk _014_ _029_ VGND VGND VPWR VPWR baud_count\[8\] sky130_fd_sc_hd__dfrtp_2
XFILLER_0_19_57 VGND VGND VPWR VPWR sky130_fd_sc_hd__decap_8
XFILLER_0_19_46 VGND VGND VPWR VPWR sky130_fd_sc_hd__decap_8
X_253_ _138_ VGND VGND VPWR VPWR _146_ sky130_fd_sc_hd__clkbuf_1
X_184_ _076_ _077_ _078_ _079_ VGND VGND VPWR VPWR _090_ sky130_fd_sc_hd__or4_2
XFILLER_0_18_132 VGND VGND VPWR VPWR sky130_fd_sc_hd__decap_8
XFILLER_0_18_121 VGND VGND VPWR VPWR sky130_fd_sc_hd__decap_8
XFILLER_0_24_113 VGND VGND VPWR VPWR sky130_fd_sc_hd__decap_6
X_167_ baud_count\[13\] baud_count\[12\] baud_count\[15\] baud_count\[14\] VGND VGND
+ VPWR VPWR _077_ sky130_fd_sc_hd__or4_1
X_305_ clknet_2_2__leaf_clk _146_ _046_ VGND VGND VPWR VPWR net11 sky130_fd_sc_hd__dfrtp_1
X_236_ _105_ _108_ _114_ _126_ VGND VGND VPWR VPWR _127_ sky130_fd_sc_hd__and4_2
XFILLER_0_15_146 VGND VGND VPWR VPWR sky130_fd_sc_hd__fill_1
XFILLER_0_1_79 VPWR VGND VPWR VGND sky130_ef_sc_hd__decap_12
XFILLER_0_1_57 VGND VGND VPWR VPWR sky130_fd_sc_hd__fill_1
Xhold15 data_reg\[2\] VGND VGND VPWR VPWR net28 sky130_fd_sc_hd__dlygate4sd3_1
X_219_ baud_count\[7\] baud_count\[6\] VGND VGND VPWR VPWR _114_ sky130_fd_sc_hd__and2_1
XFILLER_0_7_110 VGND VGND VPWR VPWR sky130_fd_sc_hd__fill_2
XTAP_108 VGND VPWR sky130_fd_sc_hd__tapvpwrvgnd_1
XPHY_2 VGND VGND VPWR VPWR sky130_fd_sc_hd__decap_3
Xclkbuf_0_clk clk VGND VGND VPWR VPWR clknet_0_clk sky130_fd_sc_hd__clkbuf_16
XFILLER_0_23_3 VPWR VGND VPWR VGND sky130_ef_sc_hd__decap_12
XFILLER_0_19_25 VGND VGND VPWR VPWR sky130_fd_sc_hd__decap_4
X_321_ clknet_2_0__leaf_clk _013_ _028_ VGND VGND VPWR VPWR baud_count\[7\] sky130_fd_sc_hd__dfrtp_1
XFILLER_0_10_27 VGND VGND VPWR VPWR sky130_fd_sc_hd__fill_1
X_252_ net36 state\[1\] _137_ VGND VGND VPWR VPWR _138_ sky130_fd_sc_hd__or3_1
X_183_ net24 _081_ _089_ VGND VGND VPWR VPWR _054_ sky130_fd_sc_hd__a21oi_1
XFILLER_0_21_15 VGND VGND VPWR VPWR sky130_fd_sc_hd__fill_2
X_304_ clknet_2_2__leaf_clk _147_ _045_ VGND VGND VPWR VPWR net12 sky130_fd_sc_hd__dfstp_1
X_235_ baud_count\[9\] baud_count\[8\] baud_count\[11\] baud_count\[10\] VGND VGND
+ VPWR VPWR _126_ sky130_fd_sc_hd__and4_1
X_166_ baud_count\[1\] baud_count\[0\] baud_count\[2\] baud_count\[3\] VGND VGND VPWR
+ VPWR _076_ sky130_fd_sc_hd__nand4_1
Xhold16 data_reg\[4\] VGND VGND VPWR VPWR net29 sky130_fd_sc_hd__dlygate4sd3_1
X_149_ net8 net26 _066_ VGND VGND VPWR VPWR _067_ sky130_fd_sc_hd__mux2_1
XFILLER_0_16_15 VPWR VGND VPWR VGND sky130_ef_sc_hd__decap_12
X_218_ baud_count\[6\] _105_ _108_ baud_count\[7\] VGND VGND VPWR VPWR _113_ sky130_fd_sc_hd__a31o_1
XTAP_109 VGND VPWR sky130_fd_sc_hd__tapvpwrvgnd_1
XFILLER_0_16_3 VPWR VGND VPWR VGND sky130_ef_sc_hd__decap_12
XPHY_3 VGND VGND VPWR VPWR sky130_fd_sc_hd__decap_3
XFILLER_0_7_57 VGND VGND VPWR VPWR sky130_fd_sc_hd__fill_2
XFILLER_0_24_15 VGND VGND VPWR VPWR sky130_fd_sc_hd__fill_1
XFILLER_0_5_3 VPWR VGND VPWR VGND sky130_ef_sc_hd__decap_12
Xclkbuf_2_0__f_clk clknet_0_clk VGND VGND VPWR VPWR clknet_2_0__leaf_clk sky130_fd_sc_hd__clkbuf_16
X_182_ state\[1\] net13 bit_index\[0\] VGND VGND VPWR VPWR _089_ sky130_fd_sc_hd__a21oi_1
X_320_ clknet_2_0__leaf_clk net23 _027_ VGND VGND VPWR VPWR baud_count\[6\] sky130_fd_sc_hd__dfrtp_1
X_251_ net10 _090_ state\[3\] VGND VGND VPWR VPWR _137_ sky130_fd_sc_hd__mux2_1
XFILLER_0_1_15 VPWR VGND VPWR VGND sky130_ef_sc_hd__decap_12
X_303_ clknet_2_2__leaf_clk _057_ _044_ VGND VGND VPWR VPWR bit_index\[3\] sky130_fd_sc_hd__dfrtp_1
X_234_ _121_ _120_ VGND VGND VPWR VPWR _125_ sky130_fd_sc_hd__nor2_1
X_165_ bit_index\[2\] bit_index\[1\] bit_index\[0\] VGND VGND VPWR VPWR _075_ sky130_fd_sc_hd__nand3_1
Xhold17 data_reg\[3\] VGND VGND VPWR VPWR net30 sky130_fd_sc_hd__dlygate4sd3_1
XFILLER_0_16_27 VGND VGND VPWR VPWR sky130_fd_sc_hd__fill_1
X_217_ net22 _109_ _112_ VGND VGND VPWR VPWR _012_ sky130_fd_sc_hd__o21a_1
X_148_ net10 state\[0\] VGND VGND VPWR VPWR _066_ sky130_fd_sc_hd__nand2_4
XFILLER_0_18_7 VGND VGND VPWR VPWR sky130_fd_sc_hd__fill_1
XFILLER_0_11_140 VGND VGND VPWR VPWR sky130_fd_sc_hd__decap_6
XPHY_4 VGND VGND VPWR VPWR sky130_fd_sc_hd__decap_3
XFILLER_0_7_25 VGND VGND VPWR VPWR sky130_fd_sc_hd__decap_6
XFILLER_0_17_70 VPWR VGND VPWR VGND sky130_ef_sc_hd__decap_12
XFILLER_0_24_49 VGND VGND VPWR VPWR sky130_fd_sc_hd__decap_6
X_250_ net14 _135_ _136_ VGND VGND VPWR VPWR _006_ sky130_fd_sc_hd__a21oi_1
X_181_ _081_ _087_ _088_ VGND VGND VPWR VPWR _055_ sky130_fd_sc_hd__a21oi_1
XFILLER_0_10_29 VGND VGND VPWR VPWR sky130_fd_sc_hd__decap_4
X_164_ _074_ VGND VGND VPWR VPWR _058_ sky130_fd_sc_hd__clkbuf_1
X_233_ _124_ VGND VGND VPWR VPWR _001_ sky130_fd_sc_hd__clkbuf_1
XFILLER_0_1_27 VPWR VGND VPWR VGND sky130_ef_sc_hd__decap_12
X_302_ clknet_2_3__leaf_clk _056_ _043_ VGND VGND VPWR VPWR bit_index\[2\] sky130_fd_sc_hd__dfrtp_1
Xhold18 data_reg\[1\] VGND VGND VPWR VPWR net31 sky130_fd_sc_hd__dlygate4sd3_1
X_216_ baud_count\[6\] _109_ _095_ VGND VGND VPWR VPWR _112_ sky130_fd_sc_hd__a21boi_1
XFILLER_0_7_146 VGND VGND VPWR VPWR sky130_fd_sc_hd__fill_1
XPHY_5 VGND VGND VPWR VPWR sky130_fd_sc_hd__decap_3
XFILLER_0_4_138 VGND VGND VPWR VPWR sky130_fd_sc_hd__fill_2
XFILLER_0_17_82 VPWR VGND VPWR VGND sky130_ef_sc_hd__decap_12
XFILLER_0_21_3 VPWR VGND VPWR VGND sky130_ef_sc_hd__decap_12
XFILLER_0_0_141 VGND VGND VPWR VPWR sky130_fd_sc_hd__decap_6
X_180_ bit_index\[0\] _081_ net20 VGND VGND VPWR VPWR _088_ sky130_fd_sc_hd__a21oi_1
X_163_ net1 net35 _066_ VGND VGND VPWR VPWR _074_ sky130_fd_sc_hd__mux2_1
X_232_ _094_ _122_ _123_ VGND VGND VPWR VPWR _124_ sky130_fd_sc_hd__and3_1
X_301_ clknet_2_3__leaf_clk _055_ _042_ VGND VGND VPWR VPWR bit_index\[1\] sky130_fd_sc_hd__dfrtp_2
XFILLER_0_1_39 VPWR VGND VPWR VGND sky130_ef_sc_hd__decap_12
Xhold19 baud_count\[8\] VGND VGND VPWR VPWR net32 sky130_fd_sc_hd__dlygate4sd3_1
XFILLER_0_16_29 VGND VGND VPWR VPWR sky130_fd_sc_hd__decap_8
X_215_ _111_ VGND VGND VPWR VPWR _011_ sky130_fd_sc_hd__clkbuf_1
XPHY_6 VGND VGND VPWR VPWR sky130_fd_sc_hd__decap_3
XFILLER_0_4_106 VPWR VGND VPWR VGND sky130_ef_sc_hd__decap_12
XFILLER_0_7_16 VGND VGND VPWR VPWR sky130_fd_sc_hd__fill_1
XFILLER_0_17_94 VPWR VGND VPWR VGND sky130_ef_sc_hd__decap_12
XFILLER_0_17_61 VGND VGND VPWR VPWR sky130_fd_sc_hd__decap_3
XFILLER_0_14_3 VGND VGND VPWR VPWR sky130_fd_sc_hd__fill_2
XFILLER_0_24_29 VGND VGND VPWR VPWR sky130_fd_sc_hd__fill_2
XFILLER_0_19_29 VGND VGND VPWR VPWR sky130_fd_sc_hd__fill_1
XFILLER_0_3_3 VPWR VGND VPWR VGND sky130_ef_sc_hd__decap_12
X_162_ _073_ VGND VGND VPWR VPWR _059_ sky130_fd_sc_hd__clkbuf_1
X_300_ clknet_2_3__leaf_clk _054_ _041_ VGND VGND VPWR VPWR bit_index\[0\] sky130_fd_sc_hd__dfrtp_4
XFILLER_0_5_60 VGND VGND VPWR VPWR sky130_fd_sc_hd__fill_2
XFILLER_0_5_93 VPWR VGND VPWR VGND sky130_ef_sc_hd__decap_12
X_231_ _121_ _120_ VGND VGND VPWR VPWR _123_ sky130_fd_sc_hd__or2_1
Xinput1 data[0] VGND VGND VPWR VPWR net1 sky130_fd_sc_hd__clkbuf_1
XTAP_90 VGND VPWR sky130_fd_sc_hd__tapvpwrvgnd_1
X_214_ _095_ _107_ _110_ VGND VGND VPWR VPWR _111_ sky130_fd_sc_hd__and3_1
XFILLER_0_2_83 VGND VGND VPWR VPWR sky130_fd_sc_hd__fill_1
XFILLER_0_11_110 VGND VGND VPWR VPWR sky130_fd_sc_hd__fill_2
XPHY_7 VGND VGND VPWR VPWR sky130_fd_sc_hd__decap_3
XFILLER_0_17_51 VGND VGND VPWR VPWR sky130_fd_sc_hd__decap_4
XFILLER_0_4_118 VPWR VGND VPWR VGND sky130_ef_sc_hd__decap_12
XFILLER_0_8_71 VPWR VGND VPWR VGND sky130_ef_sc_hd__decap_12
XFILLER_0_4_29 VGND VGND VPWR VPWR sky130_fd_sc_hd__fill_2
XFILLER_0_14_74 VGND VGND VPWR VPWR sky130_fd_sc_hd__fill_1
XFILLER_0_14_85 VGND VGND VPWR VPWR sky130_fd_sc_hd__decap_6
XFILLER_0_24_119 VGND VGND VPWR VPWR sky130_fd_sc_hd__fill_1
X_161_ net2 net31 _066_ VGND VGND VPWR VPWR _073_ sky130_fd_sc_hd__mux2_1
XFILLER_0_5_72 VGND VGND VPWR VPWR sky130_fd_sc_hd__fill_1
X_230_ _121_ _120_ VGND VGND VPWR VPWR _122_ sky130_fd_sc_hd__nand2_1
Xinput2 data[1] VGND VGND VPWR VPWR net2 sky130_fd_sc_hd__clkbuf_1
XTAP_91 VGND VPWR sky130_fd_sc_hd__tapvpwrvgnd_1
XTAP_80 VGND VPWR sky130_fd_sc_hd__tapvpwrvgnd_1
XFILLER_0_20_144 VGND VGND VPWR VPWR sky130_fd_sc_hd__decap_3
X_213_ _109_ VGND VGND VPWR VPWR _110_ sky130_fd_sc_hd__inv_2
XFILLER_0_7_116 VPWR VGND VPWR VGND sky130_ef_sc_hd__decap_12
XPHY_8 VGND VGND VPWR VPWR sky130_fd_sc_hd__decap_3
XFILLER_0_8_83 VGND VGND VPWR VPWR sky130_fd_sc_hd__fill_1
XFILLER_0_24_109 VGND VGND VPWR VPWR sky130_fd_sc_hd__decap_3
X_160_ _072_ VGND VGND VPWR VPWR _060_ sky130_fd_sc_hd__clkbuf_1
Xinput3 data[2] VGND VGND VPWR VPWR net3 sky130_fd_sc_hd__clkbuf_1
XTAP_92 VGND VPWR sky130_fd_sc_hd__tapvpwrvgnd_1
XTAP_70 VGND VPWR sky130_fd_sc_hd__tapvpwrvgnd_1
XTAP_81 VGND VPWR sky130_fd_sc_hd__tapvpwrvgnd_1
X_289_ _145_ VGND VGND VPWR VPWR _030_ sky130_fd_sc_hd__inv_2
X_212_ _105_ _108_ VGND VGND VPWR VPWR _109_ sky130_fd_sc_hd__and2_1
XFILLER_0_7_128 VPWR VGND VPWR VGND sky130_ef_sc_hd__decap_12
XFILLER_0_2_85 VGND VGND VPWR VPWR sky130_fd_sc_hd__fill_1
XPHY_9 VGND VGND VPWR VPWR sky130_fd_sc_hd__decap_3
XFILLER_0_12_3 VGND VGND VPWR VPWR sky130_fd_sc_hd__decap_8
XFILLER_0_17_140 VGND VGND VPWR VPWR sky130_fd_sc_hd__decap_6
XFILLER_0_1_3 VPWR VGND VPWR VGND sky130_ef_sc_hd__decap_12
Xinput4 data[3] VGND VGND VPWR VPWR net4 sky130_fd_sc_hd__clkbuf_1
XTAP_93 VGND VPWR sky130_fd_sc_hd__tapvpwrvgnd_1
Xclkbuf_2_1__f_clk clknet_0_clk VGND VGND VPWR VPWR clknet_2_1__leaf_clk sky130_fd_sc_hd__clkbuf_16
XTAP_60 VGND VPWR sky130_fd_sc_hd__tapvpwrvgnd_1
XTAP_71 VGND VPWR sky130_fd_sc_hd__tapvpwrvgnd_1
X_288_ _145_ VGND VGND VPWR VPWR _029_ sky130_fd_sc_hd__inv_2
XTAP_82 VGND VPWR sky130_fd_sc_hd__tapvpwrvgnd_1
X_211_ baud_count\[5\] baud_count\[4\] VGND VGND VPWR VPWR _108_ sky130_fd_sc_hd__and2_1
XFILLER_0_2_97 VPWR VGND VPWR VGND sky130_ef_sc_hd__decap_12
XFILLER_0_11_146 VGND VGND VPWR VPWR sky130_fd_sc_hd__fill_1
XFILLER_0_0_113 VGND VGND VPWR VPWR sky130_fd_sc_hd__decap_6
XFILLER_0_8_96 VGND VGND VPWR VPWR sky130_fd_sc_hd__decap_3
Xinput5 data[4] VGND VGND VPWR VPWR net5 sky130_fd_sc_hd__clkbuf_1
XFILLER_0_23_111 VGND VGND VPWR VPWR sky130_fd_sc_hd__fill_1
X_287_ _145_ VGND VGND VPWR VPWR _028_ sky130_fd_sc_hd__inv_2
XTAP_94 VGND VPWR sky130_fd_sc_hd__tapvpwrvgnd_1
XTAP_61 VGND VPWR sky130_fd_sc_hd__tapvpwrvgnd_1
XTAP_50 VGND VPWR sky130_fd_sc_hd__tapvpwrvgnd_1
XTAP_72 VGND VPWR sky130_fd_sc_hd__tapvpwrvgnd_1
XTAP_83 VGND VPWR sky130_fd_sc_hd__tapvpwrvgnd_1
XFILLER_0_14_144 VGND VGND VPWR VPWR sky130_fd_sc_hd__decap_3
X_210_ baud_count\[4\] _105_ baud_count\[5\] VGND VGND VPWR VPWR _107_ sky130_fd_sc_hd__a21o_1
XFILLER_0_6_130 VGND VGND VPWR VPWR sky130_fd_sc_hd__decap_8
XFILLER_0_6_141 VGND VGND VPWR VPWR sky130_fd_sc_hd__decap_6
XFILLER_0_17_55 VGND VGND VPWR VPWR sky130_fd_sc_hd__fill_1
XFILLER_0_3_111 VGND VGND VPWR VPWR sky130_fd_sc_hd__fill_1
XFILLER_0_0_125 VPWR VGND VPWR VGND sky130_ef_sc_hd__decap_12
XFILLER_0_14_56 VPWR VGND VPWR VGND sky130_ef_sc_hd__decap_12
XFILLER_0_18_109 VPWR VGND VPWR VGND sky130_ef_sc_hd__decap_12
X_286_ _145_ VGND VGND VPWR VPWR _027_ sky130_fd_sc_hd__inv_2
XFILLER_0_11_57 VPWR VGND VPWR VGND sky130_ef_sc_hd__decap_12
Xinput6 data[5] VGND VGND VPWR VPWR net6 sky130_fd_sc_hd__clkbuf_1
XTAP_95 VGND VPWR sky130_fd_sc_hd__tapvpwrvgnd_1
XTAP_51 VGND VPWR sky130_fd_sc_hd__tapvpwrvgnd_1
XTAP_62 VGND VPWR sky130_fd_sc_hd__tapvpwrvgnd_1
XTAP_73 VGND VPWR sky130_fd_sc_hd__tapvpwrvgnd_1
XTAP_84 VGND VPWR sky130_fd_sc_hd__tapvpwrvgnd_1
XFILLER_0_2_77 VGND VGND VPWR VPWR sky130_fd_sc_hd__decap_6
XFILLER_0_2_44 VGND VGND VPWR VPWR sky130_fd_sc_hd__fill_1
X_269_ _143_ VGND VGND VPWR VPWR _046_ sky130_fd_sc_hd__inv_2
Xmax_cap13 _080_ VGND VGND VPWR VPWR net13 sky130_fd_sc_hd__buf_1
XFILLER_0_3_145 VGND VGND VPWR VPWR sky130_fd_sc_hd__fill_2
XFILLER_0_0_137 VGND VGND VPWR VPWR sky130_fd_sc_hd__decap_3
XFILLER_0_14_68 VGND VGND VPWR VPWR sky130_fd_sc_hd__decap_6
XFILLER_0_5_55 VGND VGND VPWR VPWR sky130_fd_sc_hd__fill_1
XFILLER_0_10_3 VGND VGND VPWR VPWR sky130_fd_sc_hd__decap_8
XFILLER_0_23_146 VGND VGND VPWR VPWR sky130_fd_sc_hd__fill_1
XFILLER_0_23_113 VGND VGND VPWR VPWR sky130_fd_sc_hd__decap_4
X_285_ _145_ VGND VGND VPWR VPWR _026_ sky130_fd_sc_hd__inv_2
XFILLER_0_11_25 VGND VGND VPWR VPWR sky130_fd_sc_hd__decap_8
XFILLER_0_11_36 VPWR VGND VPWR VGND sky130_ef_sc_hd__decap_12
XFILLER_0_11_69 VGND VGND VPWR VPWR sky130_fd_sc_hd__decap_4
Xinput7 data[6] VGND VGND VPWR VPWR net7 sky130_fd_sc_hd__clkbuf_1
XTAP_96 VGND VPWR sky130_fd_sc_hd__tapvpwrvgnd_1
XTAP_52 VGND VPWR sky130_fd_sc_hd__tapvpwrvgnd_1
XTAP_63 VGND VPWR sky130_fd_sc_hd__tapvpwrvgnd_1
XTAP_74 VGND VPWR sky130_fd_sc_hd__tapvpwrvgnd_1
XTAP_85 VGND VPWR sky130_fd_sc_hd__tapvpwrvgnd_1
XFILLER_0_22_79 VGND VGND VPWR VPWR sky130_fd_sc_hd__fill_2
X_199_ _099_ VGND VGND VPWR VPWR _007_ sky130_fd_sc_hd__clkbuf_1
X_268_ _143_ VGND VGND VPWR VPWR _045_ sky130_fd_sc_hd__inv_2
XFILLER_0_11_116 VPWR VGND VPWR VGND sky130_ef_sc_hd__decap_12
Xinput10 start VGND VGND VPWR VPWR net10 sky130_fd_sc_hd__clkbuf_2
XFILLER_0_3_113 VPWR VGND VPWR VGND sky130_ef_sc_hd__decap_12
XFILLER_0_8_88 VGND VGND VPWR VPWR sky130_fd_sc_hd__decap_8
XFILLER_0_15_90 VGND VGND VPWR VPWR sky130_fd_sc_hd__fill_2
X_284_ _145_ VGND VGND VPWR VPWR _025_ sky130_fd_sc_hd__inv_2
Xinput8 data[7] VGND VGND VPWR VPWR net8 sky130_fd_sc_hd__clkbuf_1
XTAP_97 VGND VPWR sky130_fd_sc_hd__tapvpwrvgnd_1
XTAP_53 VGND VPWR sky130_fd_sc_hd__tapvpwrvgnd_1
XTAP_64 VGND VPWR sky130_fd_sc_hd__tapvpwrvgnd_1
XTAP_75 VGND VPWR sky130_fd_sc_hd__tapvpwrvgnd_1
XFILLER_0_11_48 VGND VGND VPWR VPWR sky130_fd_sc_hd__decap_8
XTAP_86 VGND VPWR sky130_fd_sc_hd__tapvpwrvgnd_1
XFILLER_0_9_141 VGND VGND VPWR VPWR sky130_fd_sc_hd__decap_6
XFILLER_0_22_69 VGND VGND VPWR VPWR sky130_fd_sc_hd__fill_2
X_198_ _097_ _094_ _098_ VGND VGND VPWR VPWR _099_ sky130_fd_sc_hd__and3_1
X_267_ _143_ VGND VGND VPWR VPWR _044_ sky130_fd_sc_hd__inv_2
XFILLER_0_11_128 VPWR VGND VPWR VGND sky130_ef_sc_hd__decap_12
XFILLER_0_3_125 VPWR VGND VPWR VGND sky130_ef_sc_hd__decap_12
X_319_ clknet_2_0__leaf_clk _011_ _026_ VGND VGND VPWR VPWR baud_count\[5\] sky130_fd_sc_hd__dfrtp_1
XFILLER_0_5_68 VGND VGND VPWR VPWR sky130_fd_sc_hd__decap_4
Xinput9 reset VGND VGND VPWR VPWR net9 sky130_fd_sc_hd__buf_2
XTAP_98 VGND VPWR sky130_fd_sc_hd__tapvpwrvgnd_1
X_283_ _145_ VGND VGND VPWR VPWR _024_ sky130_fd_sc_hd__inv_2
XTAP_54 VGND VPWR sky130_fd_sc_hd__tapvpwrvgnd_1
XTAP_65 VGND VPWR sky130_fd_sc_hd__tapvpwrvgnd_1
XTAP_76 VGND VPWR sky130_fd_sc_hd__tapvpwrvgnd_1
XTAP_87 VGND VPWR sky130_fd_sc_hd__tapvpwrvgnd_1
XFILLER_0_14_104 VGND VGND VPWR VPWR sky130_fd_sc_hd__fill_1
XFILLER_0_20_118 VGND VGND VPWR VPWR sky130_fd_sc_hd__fill_1
X_197_ baud_count\[1\] baud_count\[0\] VGND VGND VPWR VPWR _098_ sky130_fd_sc_hd__or2_1
X_266_ _143_ VGND VGND VPWR VPWR _043_ sky130_fd_sc_hd__inv_2
X_249_ net14 _135_ _095_ VGND VGND VPWR VPWR _136_ sky130_fd_sc_hd__o21ai_1
XFILLER_0_17_15 VGND VGND VPWR VPWR sky130_fd_sc_hd__decap_6
XFILLER_0_3_137 VGND VGND VPWR VPWR sky130_fd_sc_hd__decap_8
X_318_ clknet_2_0__leaf_clk _010_ _025_ VGND VGND VPWR VPWR baud_count\[4\] sky130_fd_sc_hd__dfrtp_1
Xhold1 baud_count\[15\] VGND VGND VPWR VPWR net14 sky130_fd_sc_hd__dlygate4sd3_1
XFILLER_0_5_47 VGND VGND VPWR VPWR sky130_fd_sc_hd__decap_8
XFILLER_0_17_146 VGND VGND VPWR VPWR sky130_fd_sc_hd__fill_1
XFILLER_0_23_105 VGND VGND VPWR VPWR sky130_fd_sc_hd__decap_6
X_282_ _145_ VGND VGND VPWR VPWR _023_ sky130_fd_sc_hd__inv_2
XTAP_99 VGND VPWR sky130_fd_sc_hd__tapvpwrvgnd_1
XTAP_55 VGND VPWR sky130_fd_sc_hd__tapvpwrvgnd_1
XTAP_66 VGND VPWR sky130_fd_sc_hd__tapvpwrvgnd_1
XTAP_77 VGND VPWR sky130_fd_sc_hd__tapvpwrvgnd_1
XTAP_88 VGND VPWR sky130_fd_sc_hd__tapvpwrvgnd_1
XFILLER_0_22_49 VGND VGND VPWR VPWR sky130_fd_sc_hd__fill_2
XFILLER_0_22_27 VGND VGND VPWR VPWR sky130_fd_sc_hd__fill_1
XFILLER_0_9_110 VGND VGND VPWR VPWR sky130_fd_sc_hd__fill_2
X_265_ _143_ VGND VGND VPWR VPWR _042_ sky130_fd_sc_hd__inv_2
X_196_ baud_count\[1\] baud_count\[0\] VGND VGND VPWR VPWR _097_ sky130_fd_sc_hd__nand2_1
XFILLER_0_2_15 VPWR VGND VPWR VGND sky130_ef_sc_hd__decap_12
XFILLER_0_10_141 VGND VGND VPWR VPWR sky130_fd_sc_hd__decap_6
X_248_ baud_count\[13\] baud_count\[12\] baud_count\[14\] _127_ VGND VGND VPWR VPWR
+ _135_ sky130_fd_sc_hd__and4_1
XFILLER_0_17_27 VPWR VGND VPWR VGND sky130_ef_sc_hd__decap_12
X_317_ clknet_2_0__leaf_clk _009_ _024_ VGND VGND VPWR VPWR baud_count\[3\] sky130_fd_sc_hd__dfrtp_1
X_179_ bit_index\[1\] bit_index\[0\] _086_ VGND VGND VPWR VPWR _087_ sky130_fd_sc_hd__a21o_1
Xclkbuf_2_2__f_clk clknet_0_clk VGND VGND VPWR VPWR clknet_2_2__leaf_clk sky130_fd_sc_hd__clkbuf_16
XFILLER_0_19_3 VGND VGND VPWR VPWR sky130_fd_sc_hd__fill_2
XFILLER_0_8_36 VGND VGND VPWR VPWR sky130_fd_sc_hd__decap_3
Xhold2 state\[2\] VGND VGND VPWR VPWR net15 sky130_fd_sc_hd__dlygate4sd3_1
XFILLER_0_0_81 VGND VGND VPWR VPWR sky130_fd_sc_hd__decap_3
XFILLER_0_8_3 VGND VGND VPWR VPWR sky130_fd_sc_hd__decap_4
XFILLER_0_15_60 VGND VGND VPWR VPWR sky130_fd_sc_hd__decap_6
XFILLER_0_5_15 VGND VGND VPWR VPWR sky130_fd_sc_hd__fill_1
X_281_ net9 VGND VGND VPWR VPWR _145_ sky130_fd_sc_hd__buf_4
XTAP_56 VGND VPWR sky130_fd_sc_hd__tapvpwrvgnd_1
XTAP_67 VGND VPWR sky130_fd_sc_hd__tapvpwrvgnd_1
XTAP_78 VGND VPWR sky130_fd_sc_hd__tapvpwrvgnd_1
XFILLER_0_14_139 VGND VGND VPWR VPWR sky130_fd_sc_hd__fill_1
XTAP_89 VGND VPWR sky130_fd_sc_hd__tapvpwrvgnd_1
XFILLER_0_20_109 VGND VGND VPWR VPWR sky130_fd_sc_hd__fill_1
XFILLER_0_6_91 VGND VGND VPWR VPWR sky130_fd_sc_hd__decap_6
XPHY_40 VGND VGND VPWR VPWR sky130_fd_sc_hd__decap_3
X_264_ _143_ VGND VGND VPWR VPWR _041_ sky130_fd_sc_hd__inv_2
XFILLER_0_2_38 VGND VGND VPWR VPWR sky130_fd_sc_hd__decap_6
XFILLER_0_2_27 VGND VGND VPWR VPWR sky130_fd_sc_hd__fill_1
X_195_ _096_ VGND VGND VPWR VPWR _000_ sky130_fd_sc_hd__clkbuf_1
XFILLER_0_12_50 VPWR VGND VPWR VGND sky130_ef_sc_hd__decap_12
XFILLER_0_12_94 VGND VGND VPWR VPWR sky130_fd_sc_hd__decap_6
X_247_ net16 _131_ _134_ VGND VGND VPWR VPWR _005_ sky130_fd_sc_hd__o21a_1
XFILLER_0_17_39 VPWR VGND VPWR VGND sky130_ef_sc_hd__decap_12
X_316_ clknet_2_0__leaf_clk _008_ _023_ VGND VGND VPWR VPWR baud_count\[2\] sky130_fd_sc_hd__dfrtp_1
X_178_ state\[1\] VGND VGND VPWR VPWR _086_ sky130_fd_sc_hd__inv_2
XFILLER_0_0_109 VGND VGND VPWR VPWR sky130_fd_sc_hd__decap_3
Xhold3 baud_count\[14\] VGND VGND VPWR VPWR net16 sky130_fd_sc_hd__dlygate4sd3_1
XFILLER_0_14_29 VGND VGND VPWR VPWR sky130_fd_sc_hd__fill_2
XFILLER_0_20_83 VGND VGND VPWR VPWR sky130_fd_sc_hd__fill_1
X_280_ _144_ VGND VGND VPWR VPWR _022_ sky130_fd_sc_hd__inv_2
XTAP_57 VGND VPWR sky130_fd_sc_hd__tapvpwrvgnd_1
XTAP_68 VGND VPWR sky130_fd_sc_hd__tapvpwrvgnd_1
XTAP_79 VGND VPWR sky130_fd_sc_hd__tapvpwrvgnd_1
XPHY_41 VGND VGND VPWR VPWR sky130_fd_sc_hd__decap_3
X_194_ baud_count\[0\] _095_ VGND VGND VPWR VPWR _096_ sky130_fd_sc_hd__and2b_1
X_263_ _143_ VGND VGND VPWR VPWR _040_ sky130_fd_sc_hd__inv_2
XPHY_30 VGND VGND VPWR VPWR sky130_fd_sc_hd__decap_3
XFILLER_0_10_132 VGND VGND VPWR VPWR sky130_fd_sc_hd__decap_8
XFILLER_0_12_62 VGND VGND VPWR VPWR sky130_fd_sc_hd__fill_2
XFILLER_0_23_83 VGND VGND VPWR VPWR sky130_fd_sc_hd__fill_2
XFILLER_0_23_50 VGND VGND VPWR VPWR sky130_fd_sc_hd__decap_6
X_246_ net16 _131_ _095_ VGND VGND VPWR VPWR _134_ sky130_fd_sc_hd__a21boi_1
X_177_ _085_ VGND VGND VPWR VPWR _056_ sky130_fd_sc_hd__clkbuf_1
X_315_ clknet_2_2__leaf_clk _007_ _022_ VGND VGND VPWR VPWR baud_count\[1\] sky130_fd_sc_hd__dfrtp_2
XFILLER_0_8_27 VGND VGND VPWR VPWR sky130_fd_sc_hd__fill_1
X_229_ baud_count\[10\] VGND VGND VPWR VPWR _121_ sky130_fd_sc_hd__inv_2
XFILLER_0_18_83 VGND VGND VPWR VPWR sky130_fd_sc_hd__fill_1
Xhold4 bit_index\[3\] VGND VGND VPWR VPWR net17 sky130_fd_sc_hd__dlygate4sd3_1
XFILLER_0_24_3 VPWR VGND VPWR VGND sky130_ef_sc_hd__decap_12
XFILLER_0_17_116 VPWR VGND VPWR VGND sky130_ef_sc_hd__decap_12
XTAP_58 VGND VPWR sky130_fd_sc_hd__tapvpwrvgnd_1
XTAP_69 VGND VPWR sky130_fd_sc_hd__tapvpwrvgnd_1
XPHY_42 VGND VGND VPWR VPWR sky130_fd_sc_hd__decap_3
X_193_ _094_ VGND VGND VPWR VPWR _095_ sky130_fd_sc_hd__buf_2
XPHY_31 VGND VGND VPWR VPWR sky130_fd_sc_hd__decap_3
XPHY_20 VGND VGND VPWR VPWR sky130_fd_sc_hd__decap_3
X_262_ _143_ VGND VGND VPWR VPWR _039_ sky130_fd_sc_hd__inv_2
XFILLER_0_2_29 VGND VGND VPWR VPWR sky130_fd_sc_hd__decap_6
XFILLER_0_6_138 VGND VGND VPWR VPWR sky130_fd_sc_hd__fill_2
X_245_ _133_ VGND VGND VPWR VPWR _004_ sky130_fd_sc_hd__clkbuf_1
X_314_ clknet_2_0__leaf_clk _000_ _021_ VGND VGND VPWR VPWR baud_count\[0\] sky130_fd_sc_hd__dfrtp_4
X_176_ _082_ _084_ VGND VGND VPWR VPWR _085_ sky130_fd_sc_hd__and2_1
XFILLER_0_2_141 VGND VGND VPWR VPWR sky130_fd_sc_hd__decap_6
X_159_ net3 net28 _066_ VGND VGND VPWR VPWR _072_ sky130_fd_sc_hd__mux2_1
XFILLER_0_18_40 VPWR VGND VPWR VGND sky130_ef_sc_hd__decap_12
X_228_ net21 _119_ _120_ _095_ VGND VGND VPWR VPWR _015_ sky130_fd_sc_hd__o211a_1
Xhold5 baud_count\[11\] VGND VGND VPWR VPWR net18 sky130_fd_sc_hd__dlygate4sd3_1
XFILLER_0_17_3 VPWR VGND VPWR VGND sky130_ef_sc_hd__decap_12
XFILLER_0_17_128 VPWR VGND VPWR VGND sky130_ef_sc_hd__decap_12
XFILLER_0_17_106 VGND VGND VPWR VPWR sky130_fd_sc_hd__decap_6
XTAP_59 VGND VPWR sky130_fd_sc_hd__tapvpwrvgnd_1
XFILLER_0_6_3 VPWR VGND VPWR VGND sky130_ef_sc_hd__decap_12
XPHY_43 VGND VGND VPWR VPWR sky130_fd_sc_hd__decap_3
XPHY_32 VGND VGND VPWR VPWR sky130_fd_sc_hd__decap_3
XPHY_10 VGND VGND VPWR VPWR sky130_fd_sc_hd__decap_3
X_261_ _143_ VGND VGND VPWR VPWR _038_ sky130_fd_sc_hd__inv_2
XPHY_21 VGND VGND VPWR VPWR sky130_fd_sc_hd__decap_3
X_192_ state\[2\] state\[1\] state\[3\] VGND VGND VPWR VPWR _094_ sky130_fd_sc_hd__or3_4
X_313_ clknet_2_3__leaf_clk _065_ _020_ VGND VGND VPWR VPWR data_reg\[7\] sky130_fd_sc_hd__dfrtp_1
X_244_ _094_ _130_ _132_ VGND VGND VPWR VPWR _133_ sky130_fd_sc_hd__and3_1
X_175_ bit_index\[1\] bit_index\[0\] _081_ bit_index\[2\] VGND VGND VPWR VPWR _084_
+ sky130_fd_sc_hd__a31o_1
X_158_ _071_ VGND VGND VPWR VPWR _061_ sky130_fd_sc_hd__clkbuf_1
XFILLER_0_18_85 VPWR VGND VPWR VGND sky130_ef_sc_hd__decap_12
XFILLER_0_18_52 VPWR VGND VPWR VGND sky130_ef_sc_hd__decap_12
X_227_ baud_count\[9\] baud_count\[8\] _115_ VGND VGND VPWR VPWR _120_ sky130_fd_sc_hd__nand3_2
Xhold6 state\[3\] VGND VGND VPWR VPWR net19 sky130_fd_sc_hd__buf_1
XFILLER_0_0_85 VPWR VGND VPWR VGND sky130_ef_sc_hd__decap_12
XPHY_44 VGND VGND VPWR VPWR sky130_fd_sc_hd__decap_3
XPHY_33 VGND VGND VPWR VPWR sky130_fd_sc_hd__decap_3
X_260_ _143_ VGND VGND VPWR VPWR _037_ sky130_fd_sc_hd__inv_2
XPHY_11 VGND VGND VPWR VPWR sky130_fd_sc_hd__decap_3
XFILLER_0_6_40 VPWR VGND VPWR VGND sky130_ef_sc_hd__decap_12
XPHY_22 VGND VGND VPWR VPWR sky130_fd_sc_hd__decap_3
X_191_ _093_ state\[0\] net19 net13 VGND VGND VPWR VPWR _016_ sky130_fd_sc_hd__a22o_1
XFILLER_0_6_118 VPWR VGND VPWR VGND sky130_ef_sc_hd__decap_12
XFILLER_0_10_113 VGND VGND VPWR VPWR sky130_fd_sc_hd__decap_3
X_312_ clknet_2_3__leaf_clk _064_ _053_ VGND VGND VPWR VPWR data_reg\[6\] sky130_fd_sc_hd__dfrtp_1
X_243_ _131_ VGND VGND VPWR VPWR _132_ sky130_fd_sc_hd__inv_2
X_174_ _083_ VGND VGND VPWR VPWR _057_ sky130_fd_sc_hd__clkbuf_1
XFILLER_0_23_75 VGND VGND VPWR VPWR sky130_fd_sc_hd__decap_8
XFILLER_0_23_64 VGND VGND VPWR VPWR sky130_fd_sc_hd__decap_4
XFILLER_0_23_31 VGND VGND VPWR VPWR sky130_fd_sc_hd__decap_3
XFILLER_0_2_121 VPWR VGND VPWR VGND sky130_ef_sc_hd__decap_12
X_157_ net4 net30 _066_ VGND VGND VPWR VPWR _071_ sky130_fd_sc_hd__mux2_1
XFILLER_0_18_97 VPWR VGND VPWR VGND sky130_ef_sc_hd__decap_12
XFILLER_0_18_64 VPWR VGND VPWR VGND sky130_ef_sc_hd__decap_12
X_226_ baud_count\[8\] _115_ VGND VGND VPWR VPWR _119_ sky130_fd_sc_hd__and2_1
Xhold7 bit_index\[1\] VGND VGND VPWR VPWR net20 sky130_fd_sc_hd__dlygate4sd3_1
XFILLER_0_0_97 VPWR VGND VPWR VGND sky130_ef_sc_hd__decap_12
X_209_ net34 _105_ _090_ _106_ VGND VGND VPWR VPWR _010_ sky130_fd_sc_hd__o211a_1
XFILLER_0_9_73 VGND VGND VPWR VPWR sky130_fd_sc_hd__fill_2
XFILLER_0_22_3 VGND VGND VPWR VPWR sky130_fd_sc_hd__fill_1
XFILLER_0_16_141 VGND VGND VPWR VPWR sky130_fd_sc_hd__decap_6
XFILLER_0_16_130 VGND VGND VPWR VPWR sky130_fd_sc_hd__decap_3
XFILLER_0_22_144 VGND VGND VPWR VPWR sky130_fd_sc_hd__decap_3
XPHY_12 VGND VGND VPWR VPWR sky130_fd_sc_hd__decap_3
XFILLER_0_6_52 VPWR VGND VPWR VGND sky130_ef_sc_hd__decap_12
XFILLER_0_6_85 VGND VGND VPWR VPWR sky130_fd_sc_hd__decap_3
XFILLER_0_9_116 VGND VGND VPWR VPWR sky130_fd_sc_hd__fill_2
XFILLER_0_13_111 VGND VGND VPWR VPWR sky130_fd_sc_hd__fill_1
XPHY_45 VGND VGND VPWR VPWR sky130_fd_sc_hd__decap_3
XPHY_34 VGND VGND VPWR VPWR sky130_fd_sc_hd__decap_3
X_190_ net10 VGND VGND VPWR VPWR _093_ sky130_fd_sc_hd__inv_2
XPHY_23 VGND VGND VPWR VPWR sky130_fd_sc_hd__decap_3
XFILLER_0_12_11 VGND VGND VPWR VPWR sky130_fd_sc_hd__fill_2
X_311_ clknet_2_3__leaf_clk _063_ _052_ VGND VGND VPWR VPWR data_reg\[5\] sky130_fd_sc_hd__dfrtp_1
X_242_ baud_count\[13\] baud_count\[12\] _127_ VGND VGND VPWR VPWR _131_ sky130_fd_sc_hd__and3_1
X_173_ net17 _082_ VGND VGND VPWR VPWR _083_ sky130_fd_sc_hd__and2_1
XFILLER_0_2_133 VGND VGND VPWR VPWR sky130_fd_sc_hd__decap_6
X_156_ _070_ VGND VGND VPWR VPWR _062_ sky130_fd_sc_hd__clkbuf_1
X_225_ net32 _115_ _118_ VGND VGND VPWR VPWR _014_ sky130_fd_sc_hd__o21a_1
Xhold8 baud_count\[9\] VGND VGND VPWR VPWR net21 sky130_fd_sc_hd__dlygate4sd3_1
X_208_ baud_count\[4\] _105_ _094_ VGND VGND VPWR VPWR _106_ sky130_fd_sc_hd__a21boi_1
Xclkbuf_2_3__f_clk clknet_0_clk VGND VGND VPWR VPWR clknet_2_3__leaf_clk sky130_fd_sc_hd__clkbuf_16
XFILLER_0_15_11 VGND VGND VPWR VPWR sky130_fd_sc_hd__fill_2
XFILLER_0_15_3 VGND VGND VPWR VPWR sky130_fd_sc_hd__decap_8
XFILLER_0_6_64 VPWR VGND VPWR VGND sky130_ef_sc_hd__decap_12
XFILLER_0_6_97 VGND VGND VPWR VPWR sky130_fd_sc_hd__fill_1
XPHY_46 VGND VGND VPWR VPWR sky130_fd_sc_hd__decap_3
XPHY_35 VGND VGND VPWR VPWR sky130_fd_sc_hd__decap_3
XFILLER_0_4_3 VGND VGND VPWR VPWR sky130_fd_sc_hd__decap_4
XPHY_13 VGND VGND VPWR VPWR sky130_fd_sc_hd__decap_3
XPHY_24 VGND VGND VPWR VPWR sky130_fd_sc_hd__decap_3
X_310_ clknet_2_3__leaf_clk _062_ _051_ VGND VGND VPWR VPWR data_reg\[4\] sky130_fd_sc_hd__dfrtp_1
XFILLER_0_23_22 VGND VGND VPWR VPWR sky130_fd_sc_hd__fill_1
X_241_ baud_count\[12\] _127_ baud_count\[13\] VGND VGND VPWR VPWR _130_ sky130_fd_sc_hd__a21o_1
X_172_ state\[1\] _075_ _081_ VGND VGND VPWR VPWR _082_ sky130_fd_sc_hd__a21bo_1
X_155_ net5 net29 _066_ VGND VGND VPWR VPWR _070_ sky130_fd_sc_hd__mux2_1
X_224_ baud_count\[8\] _115_ _095_ VGND VGND VPWR VPWR _118_ sky130_fd_sc_hd__a21boi_1
Xhold9 baud_count\[6\] VGND VGND VPWR VPWR net22 sky130_fd_sc_hd__dlygate4sd3_1
X_207_ baud_count\[1\] baud_count\[0\] baud_count\[2\] baud_count\[3\] VGND VGND VPWR
+ VPWR _105_ sky130_fd_sc_hd__and4_2
XFILLER_0_9_53 VGND VGND VPWR VPWR sky130_fd_sc_hd__decap_3
XFILLER_0_13_146 VGND VGND VPWR VPWR sky130_fd_sc_hd__fill_1
XPHY_47 VGND VGND VPWR VPWR sky130_fd_sc_hd__decap_3
XPHY_36 VGND VGND VPWR VPWR sky130_fd_sc_hd__decap_3
XPHY_14 VGND VGND VPWR VPWR sky130_fd_sc_hd__decap_3
XFILLER_0_6_76 VGND VGND VPWR VPWR sky130_fd_sc_hd__decap_8
XPHY_25 VGND VGND VPWR VPWR sky130_fd_sc_hd__decap_3
XFILLER_0_12_24 VGND VGND VPWR VPWR sky130_fd_sc_hd__decap_4
X_240_ net33 _127_ _129_ VGND VGND VPWR VPWR _003_ sky130_fd_sc_hd__o21a_1
X_171_ state\[0\] net13 state\[1\] VGND VGND VPWR VPWR _081_ sky130_fd_sc_hd__mux2_2
XFILLER_0_3_44 VGND VGND VPWR VPWR sky130_fd_sc_hd__fill_2
X_223_ _117_ VGND VGND VPWR VPWR _013_ sky130_fd_sc_hd__clkbuf_1
X_154_ _069_ VGND VGND VPWR VPWR _063_ sky130_fd_sc_hd__clkbuf_1
XFILLER_0_20_46 VGND VGND VPWR VPWR sky130_fd_sc_hd__decap_6
X_206_ _104_ VGND VGND VPWR VPWR _009_ sky130_fd_sc_hd__clkbuf_1
XFILLER_0_9_98 VPWR VGND VPWR VGND sky130_ef_sc_hd__decap_12
XFILLER_0_22_114 VGND VGND VPWR VPWR sky130_fd_sc_hd__fill_1
XPHY_48 VGND VGND VPWR VPWR sky130_fd_sc_hd__decap_3
XFILLER_0_20_3 VPWR VGND VPWR VGND sky130_ef_sc_hd__decap_12
XPHY_37 VGND VGND VPWR VPWR sky130_fd_sc_hd__decap_3
XPHY_15 VGND VGND VPWR VPWR sky130_fd_sc_hd__decap_3
XFILLER_0_8_141 VGND VGND VPWR VPWR sky130_fd_sc_hd__decap_6
XPHY_26 VGND VGND VPWR VPWR sky130_fd_sc_hd__decap_3
XFILLER_0_5_111 VGND VGND VPWR VPWR sky130_fd_sc_hd__fill_1
X_170_ _076_ _077_ _078_ _079_ VGND VGND VPWR VPWR _080_ sky130_fd_sc_hd__nor4_1
XFILLER_0_23_68 VGND VGND VPWR VPWR sky130_fd_sc_hd__fill_1
XFILLER_0_23_57 VGND VGND VPWR VPWR sky130_fd_sc_hd__fill_1
X_299_ clknet_2_2__leaf_clk _019_ _040_ VGND VGND VPWR VPWR state\[3\] sky130_fd_sc_hd__dfrtp_1
X_153_ net6 net25 _066_ VGND VGND VPWR VPWR _069_ sky130_fd_sc_hd__mux2_1
XFILLER_0_18_79 VGND VGND VPWR VPWR sky130_fd_sc_hd__decap_4
X_222_ _095_ _113_ _116_ VGND VGND VPWR VPWR _117_ sky130_fd_sc_hd__and3_1
X_205_ _076_ _094_ _103_ VGND VGND VPWR VPWR _104_ sky130_fd_sc_hd__and3_1
XFILLER_0_0_57 VPWR VGND VPWR VGND sky130_ef_sc_hd__decap_12
XFILLER_0_9_22 VGND VGND VPWR VPWR sky130_fd_sc_hd__decap_6
XFILLER_0_19_142 VGND VGND VPWR VPWR sky130_fd_sc_hd__decap_4
XPHY_49 VGND VGND VPWR VPWR sky130_fd_sc_hd__decap_3
XPHY_38 VGND VGND VPWR VPWR sky130_fd_sc_hd__decap_3
XPHY_16 VGND VGND VPWR VPWR sky130_fd_sc_hd__decap_3
XFILLER_0_13_3 VGND VGND VPWR VPWR sky130_fd_sc_hd__decap_8
XFILLER_0_13_104 VGND VGND VPWR VPWR sky130_fd_sc_hd__decap_3
XPHY_27 VGND VGND VPWR VPWR sky130_fd_sc_hd__decap_3
XFILLER_0_5_145 VGND VGND VPWR VPWR sky130_fd_sc_hd__fill_2
XFILLER_0_2_3 VPWR VGND VPWR VGND sky130_ef_sc_hd__decap_12
X_298_ clknet_2_0__leaf_clk _018_ _039_ VGND VGND VPWR VPWR state\[2\] sky130_fd_sc_hd__dfrtp_1
XFILLER_0_13_80 VGND VGND VPWR VPWR sky130_fd_sc_hd__decap_4
X_152_ _068_ VGND VGND VPWR VPWR _064_ sky130_fd_sc_hd__clkbuf_1
X_221_ _115_ VGND VGND VPWR VPWR _116_ sky130_fd_sc_hd__inv_2
X_204_ baud_count\[1\] baud_count\[0\] baud_count\[2\] baud_count\[3\] VGND VGND VPWR
+ VPWR _103_ sky130_fd_sc_hd__a31o_1
XFILLER_0_20_26 VGND VGND VPWR VPWR sky130_fd_sc_hd__fill_2
XFILLER_0_20_15 VGND VGND VPWR VPWR sky130_fd_sc_hd__fill_2
XFILLER_0_0_69 VPWR VGND VPWR VGND sky130_ef_sc_hd__decap_12
XFILLER_0_0_36 VPWR VGND VPWR VGND sky130_ef_sc_hd__decap_12
XFILLER_0_9_45 VGND VGND VPWR VPWR sky130_fd_sc_hd__decap_8
XFILLER_0_19_121 VGND VGND VPWR VPWR sky130_fd_sc_hd__fill_1
XFILLER_0_10_70 VGND VGND VPWR VPWR sky130_fd_sc_hd__fill_1
XFILLER_0_22_138 VGND VGND VPWR VPWR sky130_fd_sc_hd__fill_2
XPHY_17 VGND VGND VPWR VPWR sky130_fd_sc_hd__decap_3
XPHY_28 VGND VGND VPWR VPWR sky130_fd_sc_hd__decap_3
XPHY_39 VGND VGND VPWR VPWR sky130_fd_sc_hd__decap_3
XFILLER_0_4_7 VGND VGND VPWR VPWR sky130_fd_sc_hd__fill_1
XFILLER_0_5_113 VPWR VGND VPWR VGND sky130_ef_sc_hd__decap_12
XFILLER_0_23_15 VGND VGND VPWR VPWR sky130_fd_sc_hd__fill_1
X_297_ clknet_2_2__leaf_clk _017_ _038_ VGND VGND VPWR VPWR state\[1\] sky130_fd_sc_hd__dfrtp_4
X_151_ net7 net27 _066_ VGND VGND VPWR VPWR _068_ sky130_fd_sc_hd__mux2_1
X_220_ _105_ _108_ _114_ VGND VGND VPWR VPWR _115_ sky130_fd_sc_hd__and3_2
XFILLER_0_0_48 VGND VGND VPWR VPWR sky130_fd_sc_hd__decap_8
XFILLER_0_0_15 VPWR VGND VPWR VGND sky130_ef_sc_hd__decap_12
X_203_ _102_ VGND VGND VPWR VPWR _008_ sky130_fd_sc_hd__clkbuf_1
XFILLER_0_9_35 VGND VGND VPWR VPWR sky130_fd_sc_hd__decap_4
XFILLER_0_1_91 VPWR VGND VPWR VGND sky130_ef_sc_hd__decap_12
XFILLER_0_8_122 VPWR VGND VPWR VGND sky130_ef_sc_hd__decap_12
XPHY_18 VGND VGND VPWR VPWR sky130_fd_sc_hd__decap_3
XPHY_29 VGND VGND VPWR VPWR sky130_fd_sc_hd__decap_3
XFILLER_0_5_125 VPWR VGND VPWR VGND sky130_ef_sc_hd__decap_12
XFILLER_0_23_38 VGND VGND VPWR VPWR sky130_fd_sc_hd__fill_1
X_296_ clknet_2_1__leaf_clk _016_ _037_ VGND VGND VPWR VPWR state\[0\] sky130_fd_sc_hd__dfstp_1
XFILLER_0_3_15 VGND VGND VPWR VPWR sky130_fd_sc_hd__decap_6
XFILLER_0_2_139 VGND VGND VPWR VPWR sky130_fd_sc_hd__fill_1
XFILLER_0_13_60 VPWR VGND VPWR VGND sky130_ef_sc_hd__decap_12
X_150_ _067_ VGND VGND VPWR VPWR _065_ sky130_fd_sc_hd__clkbuf_1
X_279_ _144_ VGND VGND VPWR VPWR _021_ sky130_fd_sc_hd__inv_2
X_202_ _100_ _094_ _101_ VGND VGND VPWR VPWR _102_ sky130_fd_sc_hd__and3_1
XFILLER_0_0_27 VGND VGND VPWR VPWR sky130_fd_sc_hd__fill_1
XFILLER_0_10_50 VGND VGND VPWR VPWR sky130_fd_sc_hd__fill_2
XFILLER_0_6_15 VGND VGND VPWR VPWR sky130_fd_sc_hd__decap_4
XFILLER_0_16_93 VGND VGND VPWR VPWR sky130_fd_sc_hd__fill_2
XFILLER_0_8_134 VGND VGND VPWR VPWR sky130_fd_sc_hd__decap_6
XPHY_19 VGND VGND VPWR VPWR sky130_fd_sc_hd__decap_3
XTAP_110 VGND VPWR sky130_fd_sc_hd__tapvpwrvgnd_1
XFILLER_0_5_137 VGND VGND VPWR VPWR sky130_fd_sc_hd__decap_8
XFILLER_0_11_3 VGND VGND VPWR VPWR sky130_fd_sc_hd__fill_1
X_295_ net9 VGND VGND VPWR VPWR _036_ sky130_fd_sc_hd__inv_2
XFILLER_0_13_72 VGND VGND VPWR VPWR sky130_fd_sc_hd__decap_4
X_278_ _144_ VGND VGND VPWR VPWR _020_ sky130_fd_sc_hd__inv_2
XFILLER_0_0_3 VPWR VGND VPWR VGND sky130_ef_sc_hd__decap_12
XFILLER_0_20_29 VGND VGND VPWR VPWR sky130_fd_sc_hd__decap_3
X_201_ baud_count\[1\] baud_count\[0\] baud_count\[2\] VGND VGND VPWR VPWR _101_ sky130_fd_sc_hd__a21o_1
XFILLER_0_9_15 VGND VGND VPWR VPWR sky130_fd_sc_hd__decap_4
XFILLER_0_19_146 VGND VGND VPWR VPWR sky130_fd_sc_hd__fill_1
XFILLER_0_19_113 VGND VGND VPWR VPWR sky130_fd_sc_hd__decap_8
XFILLER_0_16_61 VGND VGND VPWR VPWR sky130_fd_sc_hd__decap_6
XFILLER_0_12_141 VGND VGND VPWR VPWR sky130_fd_sc_hd__decap_6
XTAP_111 VGND VPWR sky130_fd_sc_hd__tapvpwrvgnd_1
XTAP_100 VGND VPWR sky130_fd_sc_hd__tapvpwrvgnd_1
XFILLER_0_5_105 VGND VGND VPWR VPWR sky130_fd_sc_hd__decap_6
.ends
